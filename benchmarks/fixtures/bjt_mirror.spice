* bjt_mirror — one NPN + one PNP; exercises BJT recognition + LVS end-to-end.
.subckt bjt_mirror in outn outp VDD VSS
XQ1 outn in VSS sky130_fd_pr__npn_05v5_W1p00L1p00 W=1u L=1u
XQ2 outp in VDD sky130_fd_pr__pnp_05v5_W3p40L3p40
.ends bjt_mirror
